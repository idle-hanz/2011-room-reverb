* jfet_rds_2N3819
.include /workspace/compressors/spice/models/devices.lib
Vd d 0 0.01
Vg g 0 0
J1 d g 0 2N3819

.control
set wr_singlescale
set wr_vecnames
option numdgt=7
dc Vg 0 -2.98 -0.01
wrdata /workspace/compressors/spice/raw/jfet_rds_2N3819.txt i(Vd)
quit
.endc
.end
