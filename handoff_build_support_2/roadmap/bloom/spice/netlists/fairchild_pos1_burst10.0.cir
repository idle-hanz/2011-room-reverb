* fairchild_pos1_burst10.0
.include /workspace/compressors/spice/models/devices.lib
Vd drv 0 PWL(0 0 1u 6.876735208283128 10.0 6.876735208283128 10.000001 0)
D1 drv a DSIG
Rsrc a sc 100
CT sc 0 2e-06
RT sc 0 51900.0

.control
set wr_singlescale
set wr_vecnames
option numdgt=7
tran 0.0007076000000000001 14.152000000000001 0 0.0007076000000000001
wrdata /workspace/compressors/spice/raw/fairchild_pos1_burst10.0.txt v(sc)
quit
.endc
.end
