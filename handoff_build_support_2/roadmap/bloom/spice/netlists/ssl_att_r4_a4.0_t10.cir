* ssl_att_r4_a4.0_t10
.include /workspace/compressors/spice/models/devices.lib
Vin in 0 SIN(0 4.0 500 0 0 0)
Vgate g1 0 PWL(0 1 0.4 1 0.4001 0)
Bout out 0 V=v(in)*v(g1)*exp(-20.0*0.11513*v(n1))
Brect r 0 V=abs(v(out))-0.7532145960034751
D1 r d DSIG
Ra d n1 82000.0
C1 n1 0 0.47u
R9 n1 0 1200000.0

.control
set wr_singlescale
set wr_vecnames
option numdgt=7
tran 2e-06 0.4 0 2e-06
wrdata /workspace/compressors/spice/raw/ssl_att_r4_a4.0_t10.txt v(n1) v(out)
quit
.endc
.end
